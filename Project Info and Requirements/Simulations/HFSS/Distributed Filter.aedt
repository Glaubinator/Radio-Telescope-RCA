# Ansys Electronics Desktop project, version 2024.1
materials:
  vacuum: permittivity=1
  copper: permeability=0.999991 conductivity=58000000
  Rogers - RO4003C, Core, 7x1674/1x1080, 60 mil: permittivity="3.38557 + 0.0084776*ln((1e+30 + Freq*Freq)/(2.65104e+014 + Freq*Freq))" conductivity="1e-12 + 9.43253e-013*Freq*(atan(Freq/1.62820e+007) - atan(Freq/1e+15))"
  air: permittivity=1.0006 permeability=1.0000004

design HFSSDesign1 (HFSS, HFSS Modal Network, model units mm)
variables:
  CopperThickness = 0.035mm
  TL50 = 3.31558mm
  labmda = 186.875mm
geometry:
  Substrate [Rogers - RO4003C, Core, 7x1674/1x1080, 60 mil] = box(corner=(0mm, 0mm, 0mm), size=(48.054mm, 111mm, 1.524mm))
  CopperGroundLayer [copper] = box(corner=(0mm, 0mm, 0mm), size=(48.054mm, 111mm, -CopperThickness))
  Box2 [copper] = box(corner=(25.027mm, 15mm, 1.559mm), size=(4.96521mm, 11.1261mm, CopperThickness))
  Box2.move(-2.482605mm, 0mm, 0mm)
  Box3 [copper] = box(corner=(25.027mm, 26.1261mm, 1.594mm), size=(4.0366mm, (4.86504 / 2) mm, CopperThickness))
  Box3.move(0.525745mm, 0.44138mm, 0.371mm)
  Box3.move(-2.973mm, -0.44138mm, -0.406mm)
  Box4 = box(corner=(25.027mm, 28.55862mm, 1.594mm), size=(4.8946mm, (4.86504 / 2) mm, CopperThickness))
  Box4.move(-0.7946725mm, 0mm, 0mm)
  Box4.move(0.0632375mm, 3.5527137e-15mm, -0.035mm)
  Box3.move(0.428955mm, 0mm, 0mm)
  Box3.move(0.464305mm, 0mm, 0mm)
  Box4.move(-1.68056mm, 0mm, 0mm)
  Box5 = box(corner=(27.509605mm, 28.55862mm, 1.594mm), size=(8.71625mm, 4.96887mm, CopperThickness))
  Box6 [copper] = box(corner=(25.062305mm, 30.99114mm, 1.594mm), size=(2.38975mm, 12.9749mm, CopperThickness))
  Box6.move(-1.194875mm, 0mm, -0.035mm)
  Box7 [copper] = box(corner=(25.062305mm, 43.96604mm, 1.594mm), size=(2.72985mm, (2.72937 /2) mm, CopperThickness))
  Box7.move(-1.364925mm, 0mm, -0.07mm)
  Box7.move(-0.17005mm, 0mm, 0.035mm)
  Box8 = box(corner=(24.892255mm, 45.330725mm, 1.559mm), size=(2.6377mm, (2.72937 / 2) mm, CopperThickness))
  Box8.move(-1.272775mm, 7.1054274e-15mm, 0mm)
  Box9 [copper] = box(corner=(22.3mm, 46.8mm, 1.594mm), size=(18.0978mm, 2.69108mm, CopperThickness))
  Box9.move(3.95718mm, -2.814815mm, -0.035mm)
  Box10 [copper] = box(corner=(22.34mm, 45.54mm, 1.594mm), size=(2.67098mm, 16.3mm, CopperThickness))
  Box10.move(1.26284mm, 1.15541mm, -0.035mm)
  coordinate_system RelativeCS1 = origin=(24.027mm, 111mm, 1.524mm) x=(1mm, 0mm, 0mm) y=(0mm, 1mm, 0mm)
  Polyline4 [copper] = imported_body()
  Box11 = box(corner=(24.93833mm, 62.99541mm, 1.594mm), size=(3.1706mm, (2.3451/2) mm, CopperThickness))
  Box11.move(-1.83511mm, 0mm, -0.035mm)
  Box12 [copper] = box(corner=(24.68852mm, 64.16796mm, 1.594mm), size=(2.8426mm, (2.3451/2) mm, CopperThickness))
  Box12.move(-1.2573mm, 0mm, -0.035mm)
  Polyline5 [copper] = imported_body()
  Polyline5.move(3.5527137e-15mm, -111mm, -0.035mm)
  coordinate_system RelativeCS2 = origin=(24.027mm, 0mm, 1.524mm) x=(1mm, 0mm, 0mm) y=(0mm, 1mm, 0mm)
  Polyline5.rotate(axis=Z, angle=180deg) in RelativeCS2
  Polyline5.move(0mm, 0mm, 1mm) in RelativeCS2
  Polyline5.move(0mm, 0mm, -0.965mm) in RelativeCS2
  Box5.move(0mm, -2.484435mm, -0.035mm)
  Box9.move(-1mm, -1.7763568e-15mm, -0.035mm)
  Box11.move(-1mm, 0mm, -0.035mm)
  Box11.move(1mm, 0mm, 0.035mm)
  Box13 [copper] = box(corner=(26.27382mm, 64.16796mm, 1.559mm), size=(10.4875mm, 2.00339mm, CopperThickness))
  Box13.move(0.3mm, 0mm, 0mm)
  Box13.move(-0.3mm, -1.001695mm, 0mm)
  Box14 [copper] = box(corner=(24.85252mm, 65.34051mm, 1.594mm), size=(3.315mm, 10mm, CopperThickness))
  Box14.move(-1.6575mm, 0mm, -0.0175mm)
  Box14.move(-0.05252mm, 1.05949mm, -0.0115mm)
  Box14.move(0.05252mm, -1.05949mm, -0.006mm)
  Box13.move(-1mm, -1.7763568e-15mm, -0.035mm)
  Box15 [copper] = box(corner=(23.85252mm, 75.34051mm, 1.559mm), size=(33.192mm, 3.315mm, CopperThickness))
  Box15.move(-16.596mm, 1.6575mm, 0mm)
  Box15.move(-7.1054274e-15mm, -1.6575mm, -0.035mm)
  Box16 [copper] = box(corner=(24mm, 78.82471mm, 1.594mm), size=(29.67mm, 3.315mm, CopperThickness))
  Box16.move(-14.90874mm, 2.8421709e-14mm, -0.07mm)
  Box16.move(1.68726mm, 0mm, 0mm)
  Box17 [copper] = box(corner=(16.68mm, 83.54mm, 0mm), size=(33.192mm, 3.315mm, CopperThickness))
  Box17.move(-9.6mm, 1.8mm, 0mm)
  Box17.move(0.17652mm, -3.20029mm, 1.524mm)
  Box17.move(0mm, 0.1692mm, 0mm)
  Box18 [copper] = box(corner=(23mm, 87mm, 1.594mm), size=(3.315mm, 10.376mm, CopperThickness))
  Box18.move(-0.80498mm, -1.37609mm, -0.07mm)
  Box18.move(0.17448mm, 0.37609mm, 4.4408921e-16mm)
  Box18.move(0mm, -0.376mm, 0mm)
  Rectangle2 = rectangle(corner=(23.027mm, 111mm, 1.559mm), z_size=(-1.559-0.035) mm, x_size=2mm)
  Rectangle3 = rectangle(corner=(23.027mm, 0mm, 1.559mm), z_size=(-1.559-0.035) mm, x_size=2mm)
  Cylinder1 = cylinder(axis=Z, base_centre=(40.44852mm, 76.99801mm, 1.559mm), radius=0.8mm, height=-1.559mm)
  Cylinder1.move(-0.8mm, 0mm, 0mm)
  Cylinder2 = cylinder(axis=Z, base_centre=(40.44852mm, 83.96641mm, 1.559mm), radius=0.8mm, height=-1.559mm)
  Cylinder2.move(-0.8mm, 0mm, 0mm)
  Cylinder3 = cylinder(axis=Z, base_centre=(10.77852mm, 80.48221mm, 1.559mm), radius=0.8mm, height=-1.559mm)
  Cylinder3.move(0.8mm, 0mm, 0mm)
  Substrate.subtract(Cylinder1)
  Substrate.subtract(Cylinder2)
  Substrate.subtract(Cylinder3)
  Cylinder4 [copper] = cylinder(axis=Z, base_centre=(39.64852mm, 77.79801mm, 1.524mm), radius=0.8mm, height=-1.524mm)
  Cylinder4.move(0mm, -0.8mm, 0mm)
  Cylinder5 [copper] = cylinder(axis=Z, base_centre=(39.64852mm, 84.76641mm, 1.524mm), radius=0.8mm, height=-1.524mm)
  Cylinder5.move(0mm, -0.8mm, 0mm)
  Cylinder6 [copper] = cylinder(axis=Z, base_centre=(12.37852mm, 80.48221mm, 1.524mm), radius=0.8mm, height=-1.524mm)
  Cylinder6.move(-0.8mm, 2.8421709e-14mm, 0mm)
  Box3.unite(Box4)
  Box9.move(1mm, 0mm, 0.035mm)
  Box7.unite(Box8)
  Box13.move(1mm, 0mm, 0.035mm)
  Box12.unite(Box11)
  Box2.move(-1mm, 1.0658141e-14mm, -0.035mm)
  Box3.move(-1.464305mm, 1.0658141e-14mm, -0.035mm)
  Box5.move(-1.464305mm, 1.4210855e-14mm, -0.035mm)
  Box6.move(-1.464305mm, 1.0658141e-14mm, -0.035mm)
  [Box9, Box10, Box7, Box13, Box12, Box14].move(-1.294255mm, 7.1054274e-15mm, -0.035mm)
  Box5.move(0mm, (0.041379999999982 + 0.01052) mm, 0mm)
  Region [air] = region(absolute_offset=labmda/4 on all sides)
  Box2.unite(Box5)
boundaries and excitations:
  GND: Perfect E Faces=CopperGroundLayer.face(-z) InfGroundPlane
  Rad1: Radiation Objects=Region
  1: Lumped Port Objects=Rectangle3 LumpedPortType=Modal Modes{Mode1{IntLine{(24.027, 0, -0.035) -> (24.027, 0, 1.559)} CharImp=Zpi RenormImp=50ohm}} Impedance=50
  2: Lumped Port Objects=Rectangle2 LumpedPortType=Modal Modes{Mode1{IntLine{(24.027, 111, -0.035) -> (24.027, 111, 1.559)} CharImp=Zpi RenormImp=50ohm}} Impedance=50ohm
  reference conductors: CopperGroundLayer
setups:
  Setup2: HfssDriven Frequency=1.2GHz MaxDeltaS=0.02 MaximumPasses=6 MinimumPasses=1 MinimumConvergedPasses=1 PercentRefinement=30 BasisOrder=1 PortAccuracy=2 DrivenSolverType="Direct Solver"
    sweep Sweep: 0.5GHz to 3.8GHz, 401 points; Type=Interpolating InterpTolerance=0.5 InterpMaxSolns=250 InterpUsePortImped=false PassivityErrorTolerance=0.0001
source amplitudes:
  1:1: 1W 0deg
  2:1: 0W 0deg
reports:
  S Parameter Plot 1: dB(S(1,1)) vs Freq on Setup2 : Sweep; markers m1 at 1.2GHz, m2 at 1.42GHz, m3 at 1.6GHz
  S Parameter Plot 2: dB(S(2,1)) vs Freq on Setup2 : Sweep; markers m1 at 1.2GHz, m2 at 1.42GHz, m3 at 1.6GHz
  S Parameter Plot 3: dB(S(2,2)) vs Freq on Setup2 : Sweep
  S Parameter Plot 4: dB(S(1,1)), dB(S(2,2)) vs Freq on Setup2 : Sweep; markers m1 at 1.2GHz, m2 at 1.42GHz, m3 at 1.6GHz
