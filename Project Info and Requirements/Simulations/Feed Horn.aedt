# Ansys Electronics Desktop project, version 2024.1
materials:
  PMLGroup4_XYZ_1: permittivity{anisotropic component1=1.1 component2=1.1 component3=1.1} permeability{anisotropic component1=1.1 component2=1.1 component3=1.1} dielectric_loss_tangent{anisotropic component1=1 component2=1 component3=1} magnetic_loss_tangent{anisotropic component1=1 component2=1 component3=1}
  PMLGroup4_XZ_1: permittivity{anisotropic component1=1 component2=0.01 component3=1} permeability{anisotropic component1=1 component2=0.01 component3=1} dielectric_loss_tangent{anisotropic component1=0 component2=242 component3=0} magnetic_loss_tangent{anisotropic component1=0 component2=242 component3=0}
  PMLGroup4_YZ_1: permittivity{anisotropic component1=0.01 component2=1 component3=1} permeability{anisotropic component1=0.01 component2=1 component3=1} dielectric_loss_tangent{anisotropic component1=242 component2=0 component3=0} magnetic_loss_tangent{anisotropic component1=242 component2=0 component3=0}
  PMLGroup4_Z_1: permittivity{anisotropic component1=1.1 component2=1.1 component3=0.45454545} permeability{anisotropic component1=1.1 component2=1.1 component3=0.45454545} dielectric_loss_tangent{anisotropic component1=1 component2=1 component3=-1} magnetic_loss_tangent{anisotropic component1=1 component2=1 component3=-1}
  copper: permeability=0.999991 conductivity=58000000
  vacuum: permittivity=1
  PMLGroup4_Z_2: permittivity{anisotropic component1=1.1 component2=1.1 component3=0.45454545} permeability{anisotropic component1=1.1 component2=1.1 component3=0.45454545} dielectric_loss_tangent{anisotropic component1=1 component2=1 component3=-1} magnetic_loss_tangent{anisotropic component1=1 component2=1 component3=-1}
  PMLGroup4_XZ_2: permittivity{anisotropic component1=1 component2=0.01 component3=1} permeability{anisotropic component1=1 component2=0.01 component3=1} dielectric_loss_tangent{anisotropic component1=0 component2=242 component3=0} magnetic_loss_tangent{anisotropic component1=0 component2=242 component3=0}
  PMLGroup4_YZ_2: permittivity{anisotropic component1=0.01 component2=1 component3=1} permeability{anisotropic component1=0.01 component2=1 component3=1} dielectric_loss_tangent{anisotropic component1=242 component2=0 component3=0} magnetic_loss_tangent{anisotropic component1=242 component2=0 component3=0}
  PMLGroup4_XYZ_2: permittivity{anisotropic component1=1.1 component2=1.1 component3=1.1} permeability{anisotropic component1=1.1 component2=1.1 component3=1.1} dielectric_loss_tangent{anisotropic component1=1 component2=1 component3=1} magnetic_loss_tangent{anisotropic component1=1 component2=1 component3=1}

design Feed Horn (HFSS, HFSS Modal Network, model units mm)
variables:
  dR = 1.78695mm  # optimise 1.32mm..3.96mm
  dL = 50.59072mm  # optimise 24.6784mm..74.0352mm
  gL = 0.5mm
  Wavelength = 0.21056338meter
  length = 50mm
  heightOfGroundPlane = 2mm
  lengthOfNConnector = 25.4mm
  a = 164mm
  c = 185mm
  b = 81.8mm
  l1 = -43.9mm
  d1 = 306mm
geometry:
  Dipole [copper] = cylinder(axis=Z, base_centre=(0mm, 0mm, 0), radius=dR, height=dL)
  Gap [vacuum] = cylinder(axis=Z, base_centre=(0mm, 0mm, 0), radius=dR, height=gL)
  Gap_1 = Gap.copy()
  Dipole.subtract(Gap_1)
  Gap_Section1 = Gap.section(plane=YZ)
  Box1 [copper] = box(corner=(-length/2, -length/2, -heightOfGroundPlane), size=(length, length, 2mm))
  Cylinder1 = cylinder(axis=Z, base_centre=(-5.5mm, -5.5mm, -2mm), radius=1.6mm, height=2mm)
  Box1.subtract(Cylinder1)
  Cylinder2 = cylinder(axis=Z, base_centre=(5.5mm, 5.5mm, -2mm), radius=1.6mm, height=2mm)
  Box1.subtract(Cylinder2)
  Cylinder3 = cylinder(axis=Z, base_centre=(-5.5mm, 5.5mm, -2mm), radius=1.6mm, height=2mm)
  Cylinder4 = cylinder(axis=Z, base_centre=(5.5mm, -5.5mm, -2mm), radius=1.6mm, height=2mm)
  Box1.subtract(Cylinder4)
  Box1.subtract(Cylinder3)
  Rectangle1 = rectangle(corner=(-82mm, -43.9mm, 81.8mm), x_size=164mm, y_size=185mm)
  Rectangle2 = rectangle(corner=(82mm, -43.9mm, 0mm), z_size=81.8mm, x_size=-164mm)
  Rectangle3 = rectangle(corner=(82mm, -43.9mm, 81.8mm), y_size=185mm, z_size=-81.8mm)
  Rectangle4 = rectangle(corner=(-82mm, 141.1mm, 81.8mm), y_size=-185mm, z_size=-81.8mm)
  Rectangle5 = rectangle(corner=(82mm, 141.1mm, 0mm), x_size=-164mm, y_size=-185mm)
  Polyline1 = polyline(xyz in mm: (-257.5, 418.1, 212.4) (257.5, 418.1, 212.4) (82, 141.1, 81.8) (-82, 141.1, 81.8) (-257.5, 418.1, 212.4), closed, covered)
  Polyline2 = polyline(xyz in mm: (82, 141.1, 81.8) (257.5, 418.1, 212.4) (257.5, 418.1, -130.6) (82, 141.1, 0) (82, 141.1, 81.8), closed, covered)
  Polyline3 = polyline(xyz in mm: (-82, 141.1, 0) (82, 141.1, 0) (257.5, 418.1, -130.6) (-257.5, 418.1, -130.6) (-82, 141.1, 0), closed, covered)
  Polyline4 = polyline(xyz in mm: (-257.5, 418.1, -130.6) (-257.5, 418.1, 212.4) (-82, 141.1, 81.8) (-82, 141.1, 0) (-257.5, 418.1, -130.6), closed, covered)
  RadiatingSurface [vacuum] = region(absolute_offset=52.816901mm on all sides)
  coordinate_system FaceCS1 = face of RadiatingSurface: Origin=(310.3169, -96.716901, 265.2169) FaceID=RadiatingSurface.face(+z) AxisPosn=(310.3169, 470.9169, 265.2169) WhichAxis=X ZRotationAngle=0deg XOffset=0mm YOffset=0mm FaceNormal(0, 0, 1)
  PML_RadiatingSurface_1 [PMLGroup4_Z_2, oriented by FaceCS1] = sweep_along_normal(RadiatingSurface.face(+z), length=270.97538mm)
  coordinate_system FaceCS2 = face of RadiatingSurface: Origin=(310.3169, -96.716901, -183.4169) FaceID=RadiatingSurface.face(-z) AxisPosn=(-310.3169, -96.716901, -183.4169) WhichAxis=X ZRotationAngle=0deg XOffset=0mm YOffset=0mm FaceNormal(0, 0, -1)
  PML_RadiatingSurface_2 [PMLGroup4_Z_2, oriented by FaceCS2] = sweep_along_normal(RadiatingSurface.face(-z), length=270.97538mm)
  coordinate_system FaceCS3 = face of RadiatingSurface: Origin=(310.3169, -96.716901, 265.2169) FaceID=RadiatingSurface.face(-y) AxisPosn=(-310.3169, -96.716901, 265.2169) WhichAxis=X ZRotationAngle=0deg XOffset=0mm YOffset=0mm FaceNormal(0, -1, 0)
  PML_RadiatingSurface_3 [PMLGroup4_Z_2, oriented by FaceCS3] = sweep_along_normal(RadiatingSurface.face(-y), length=270.97538mm)
  coordinate_system FaceCS4 = face of RadiatingSurface: Origin=(-310.3169, -96.716901, 265.2169) FaceID=RadiatingSurface.face(-x) AxisPosn=(-310.3169, 470.9169, 265.2169) WhichAxis=X ZRotationAngle=0deg XOffset=0mm YOffset=0mm FaceNormal(-1, 0, 0)
  PML_RadiatingSurface_4 [PMLGroup4_Z_2, oriented by FaceCS4] = sweep_along_normal(RadiatingSurface.face(-x), length=270.97538mm)
  coordinate_system FaceCS5 = face of RadiatingSurface: Origin=(-310.3169, 470.9169, 265.2169) FaceID=RadiatingSurface.face(+y) AxisPosn=(310.3169, 470.9169, 265.2169) WhichAxis=X ZRotationAngle=0deg XOffset=0mm YOffset=0mm FaceNormal(0, 1, 0)
  PML_RadiatingSurface_5 [PMLGroup4_Z_2, oriented by FaceCS5] = sweep_along_normal(RadiatingSurface.face(+y), length=270.97538mm)
  coordinate_system FaceCS6 = face of RadiatingSurface: Origin=(310.3169, 470.9169, -183.4169) FaceID=RadiatingSurface.face(+x) AxisPosn=(310.3169, 470.9169, 265.2169) WhichAxis=X ZRotationAngle=0deg XOffset=0mm YOffset=0mm FaceNormal(1, 0, 0)
  PML_RadiatingSurface_6 [PMLGroup4_Z_2, oriented by FaceCS6] = sweep_along_normal(RadiatingSurface.face(+x), length=270.97538mm)
  PML_RadiatingSurface_7 [PMLGroup4_XZ_2, oriented by FaceCS1] = sweep_along_normal(PML_RadiatingSurface_1.face(at (0, -96.7169, 400.705)), length=270.97538mm)
  PML_RadiatingSurface_8 [PMLGroup4_YZ_2, oriented by FaceCS4] = sweep_along_normal(PML_RadiatingSurface_1.face(at (-310.317, 187.1, 400.705)), length=270.97538mm)
  PML_RadiatingSurface_9 [PMLGroup4_YZ_2, oriented by FaceCS5] = sweep_along_normal(PML_RadiatingSurface_1.face(at (0, 470.917, 400.705)), length=270.97538mm)
  PML_RadiatingSurface_10 [PMLGroup4_YZ_2, oriented by FaceCS1] = sweep_along_normal(PML_RadiatingSurface_1.face(at (310.317, 187.1, 400.705)), length=270.97538mm)
  PML_RadiatingSurface_11 [PMLGroup4_YZ_2, oriented by FaceCS2] = sweep_along_normal(PML_RadiatingSurface_2.face(at (0, -96.7169, -318.905)), length=270.97538mm)
  coordinate_system FaceCS7 = face of RadiatingSurface: Origin=(-310.3169, -96.716901, -183.4169) FaceID=RadiatingSurface.face(-z) AxisPosn=(-310.3169, 470.9169, -183.4169) WhichAxis=X ZRotationAngle=0deg XOffset=0mm YOffset=0mm FaceNormal(0, 0, -1)
  PML_RadiatingSurface_12 [PMLGroup4_YZ_2, oriented by FaceCS7] = sweep_along_normal(PML_RadiatingSurface_2.face(at (-310.317, 187.1, -318.905)), length=270.97538mm)
  coordinate_system FaceCS8 = face of RadiatingSurface: Origin=(-310.3169, 470.9169, -183.4169) FaceID=RadiatingSurface.face(-z) AxisPosn=(310.3169, 470.9169, -183.4169) WhichAxis=X ZRotationAngle=0deg XOffset=0mm YOffset=0mm FaceNormal(0, 0, -1)
  PML_RadiatingSurface_13 [PMLGroup4_YZ_2, oriented by FaceCS8] = sweep_along_normal(PML_RadiatingSurface_2.face(at (0, 470.917, -318.905)), length=270.97538mm)
  PML_RadiatingSurface_14 [PMLGroup4_XZ_2, oriented by FaceCS2] = sweep_along_normal(PML_RadiatingSurface_2.face(at (310.317, 187.1, -318.905)), length=270.97538mm)
  PML_RadiatingSurface_15 [PMLGroup4_XZ_2, oriented by FaceCS4] = sweep_along_normal(PML_RadiatingSurface_3.face(at (-310.317, -232.205, 40.9)), length=270.97538mm)
  PML_RadiatingSurface_16 [PMLGroup4_XZ_2, oriented by FaceCS3] = sweep_along_normal(PML_RadiatingSurface_3.face(at (310.317, -232.205, 40.9)), length=270.97538mm)
  PML_RadiatingSurface_17 [PMLGroup4_XZ_2, oriented by FaceCS5] = sweep_along_normal(PML_RadiatingSurface_4.face(at (-445.805, 470.917, 40.9)), length=270.97538mm)
  PML_RadiatingSurface_18 [PMLGroup4_YZ_2, oriented by FaceCS6] = sweep_along_normal(PML_RadiatingSurface_5.face(at (310.317, 606.405, 40.9)), length=270.97538mm)
  PML_RadiatingSurface_19 [PMLGroup4_XYZ_2, oriented by FaceCS4] = sweep_along_normal(PML_RadiatingSurface_7.face(at (-310.317, -232.205, 400.705)), length=270.97538mm)
  PML_RadiatingSurface_20 [PMLGroup4_XYZ_2, oriented by FaceCS1] = sweep_along_normal(PML_RadiatingSurface_7.face(at (310.317, -232.205, 400.705)), length=270.97538mm)
  PML_RadiatingSurface_21 [PMLGroup4_XYZ_2, oriented by FaceCS5] = sweep_along_normal(PML_RadiatingSurface_8.face(at (-445.805, 470.917, 400.705)), length=270.97538mm)
  coordinate_system FaceCS9 = face of RadiatingSurface: Origin=(310.3169, 470.9169, 265.2169) FaceID=RadiatingSurface.face(+z) AxisPosn=(-310.3169, 470.9169, 265.2169) WhichAxis=X ZRotationAngle=0deg XOffset=0mm YOffset=0mm FaceNormal(0, 0, 1)
  PML_RadiatingSurface_22 [PMLGroup4_XYZ_2, oriented by FaceCS9] = sweep_along_normal(PML_RadiatingSurface_9.face(at (310.317, 606.405, 400.705)), length=270.97538mm)
  PML_RadiatingSurface_23 [PMLGroup4_XYZ_2, oriented by FaceCS7] = sweep_along_normal(PML_RadiatingSurface_11.face(at (-310.317, -232.205, -318.905)), length=270.97538mm)
  PML_RadiatingSurface_24 [PMLGroup4_XYZ_2, oriented by FaceCS2] = sweep_along_normal(PML_RadiatingSurface_11.face(at (310.317, -232.205, -318.905)), length=270.97538mm)
  PML_RadiatingSurface_25 [PMLGroup4_XYZ_2, oriented by FaceCS8] = sweep_along_normal(PML_RadiatingSurface_12.face(at (-445.805, 470.917, -318.905)), length=270.97538mm)
  PML_RadiatingSurface_26 [PMLGroup4_XYZ_2, oriented by FaceCS6] = sweep_along_normal(PML_RadiatingSurface_13.face(at (310.317, 606.405, -318.905)), length=270.97538mm)
  group PMLGroup4 = PML_RadiatingSurface_1..PML_RadiatingSurface_26
boundaries and excitations:
  PerfE1: Perfect E Objects=Box1
  PML_radiation1: Radiation Faces=RadiatingSurface.face(+z) IsForPML
  PML_radiation2: Radiation Faces=RadiatingSurface.face(-z) IsForPML
  PML_radiation3: Radiation Faces=RadiatingSurface.face(-y) IsForPML
  PML_radiation4: Radiation Faces=RadiatingSurface.face(-x) IsForPML
  PML_radiation5: Radiation Faces=RadiatingSurface.face(+y) IsForPML
  PML_radiation6: Radiation Faces=RadiatingSurface.face(+x) IsForPML
  FiniteCond1: Finite Conductivity Objects=[Polyline1..Polyline4, Rectangle1..Rectangle5] Conductivity=23700000 Permeability=1 IsInternal
  1: Lumped Port Objects=Gap_Section1 LumpedPortType=Modal Modes{Mode1{IntLine{(0, 0, 0) -> (0, 0, 0.5)} CharImp=Zpi RenormImp=50ohm}} Impedance=50ohm
setups:
  142GHz: HfssDriven Frequency=1.2GHz MaxDeltaS=0.02 MaximumPasses=99 MinimumPasses=1 MinimumConvergedPasses=1 PercentRefinement=30 BasisOrder=1 PortAccuracy=2 DrivenSolverType="Direct Solver" VariablesForDerivatives(dL, dR, gL, length) VariableFlagsForDerivatives(1, 1, 1, 1) InfiniteSphereSetup=35
    sweep Sweep: 0.6GHz to 1.8GHz, 401 points; Type=Interpolating InterpTolerance=0.5 InterpMaxSolns=250 InterpUsePortImped=false PassivityErrorTolerance=0.0001
source amplitudes:
  1:1: 1W 0deg
optimetrics:
  OptimizationSetup1: Optimization disabled Optimizer="DX SCREENING" AnalysisStopOptions{StopForNumIteration MaxNumIteration=100 MinNumIteration=10} CostFuncNormType=L2 Acceptable_Cost=0 Noise=0.0001 UpdateDesignWhenDone
    goal dB(S(1,1)) <= -10 weight 1 on 142GHz : Sweep at Freq 0.6GHz to 1.8GHz
radiation setups:
  3D: Infinite Sphere Theta=0deg..180deg step 2deg Phi=-180deg..180deg step 2deg
  Elevation: Infinite Sphere Theta=-180deg..180deg step 1deg Phi=0deg..90deg step 90deg
  Azimuth: Infinite Sphere Theta=90deg..90deg step 0deg Phi=-180deg..180deg step 1deg
reports:
  Gain Plot 1: dB(GainTotal) vs Phi, Theta on 142GHz : LastAdaptive, 3D [Freq=1.42GHz]
  Gain Plot 2: dB(GainTotal) vs Theta on 142GHz : LastAdaptive, 3D [Phi=all Freq=1.42GHz]
  S Parameter Plot 1: dB(S(1,1)) vs Freq on 142GHz : Sweep [dR=all dL=50.5907mm]; markers m1 at 1.197GHz, m2 at 1.2GHz, m3 at 1.42GHz, m4 at 1.6GHz, m5 at 0.999GHz, m6 at 1.2GHz, m8 at 1.42GHz, m9 at 1.6GHz
  Z Parameter Plot 1: mag(Z(1,1)) vs Freq on 142GHz : Sweep [dR=all dL=all]
  Z Parameter Plot 2: re(Z(1,1)), im(Z(1,1)) vs Freq on 142GHz : Sweep [dR=all dL=all]; markers m1 at 1.6GHz
